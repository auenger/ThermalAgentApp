# Ansys Electronics Desktop project, version 2024.2
materials:
  Al-Extruded: thermal_conductivity=205 mass_density=2800 specific_heat=900 youngs_modulus=69000000000 poissons_ratio=0.33 thermal_expansion_coefficient=2.277e-06 thermal_material_type=Solid
  air: permittivity=1.0006 permeability=1.0000004 thermal_conductivity=0.0261 mass_density=1.1614 specific_heat=1005 thermal_expansion_coefficient=0.00333 thermal_material_type=Fluid diffusivity=2.88e-05 molecular_mass=0.028966 viscosity=1.84e-05 material_refractive_index=1.000293
  TIM579: thermal_conductivity=3 mass_density=2900 specific_heat=1 thermal_expansion_coefficient=150
  HP: permeability=0.999991 conductivity=58000000 thermal_conductivity=1500 mass_density=8933 specific_heat=385 youngs_modulus=120000000000 poissons_ratio=0.38 thermal_expansion_coefficient=1.77e-05
  copper: permeability=0.999991 conductivity=58000000 thermal_conductivity=400 mass_density=8933 specific_heat=385 youngs_modulus=120000000000 poissons_ratio=0.38 thermal_expansion_coefficient=1.77e-05
  FR-4: thermal_conductivity=0.35 mass_density=1250 specific_heat=1300 thermal_material_type=Solid
surface materials:
  Steel-oxidised-surface: surface_emissivity=0.8

design IcepakDesign1 (Icepak, SteadyState TemperatureAndFlow, model units mm)
options: Default_Fluid_Material=air Default_Solid_Material=Al-Extruded Default_Surface_Material=Steel-oxidised-surface AmbientTemperature=20cel AmbientPressure=0n_per_meter_sq AmbientRadiationTemperature=20cel Gravity_Vector_CS_ID=Global Gravity_Vector_Axis=Z Positive=false SherlockExportDirectory="E:/Icepak Test/Project1.aedtexport/IcepakDesign1/" Altitude=0meter OperatingPressure=101325n_per_meter_sq OperatingDensity=1.225kg_per_m3
geometry:
  Region [air] = region(percentage_offset=50 on all sides)
  FIN [Al-Extruded] = imported_body(C:\Users\hzh66\Desktop\afrm_odo-for_psc__110156-00__asm.stp)
  CuBase [copper] = imported_body(C:\Users\hzh66\Desktop\afrm_odo-for_psc__110156-00__asm.stp)
  HP_2, HP, HP_1 [HP] = imported_body(C:\Users\hzh66\Desktop\afrm_odo-for_psc__110156-00__asm.stp)
  AlBase [Al-Extruded] = imported_body(C:\Users\hzh66\Desktop\afrm_odo-for_psc__110156-00__asm.stp)
  TIM579_1, TIM579 [TIM579] = imported_body(C:\Users\hzh66\Desktop\afrm_odo-for_psc__110156-00__asm.stp)
  Chip2 [copper] = imported_body(C:\Users\hzh66\Desktop\afrm_odo-for_psc__110156-00__asm.stp)
  PSU [FR-4] = imported_body(C:\Users\hzh66\Desktop\afrm_odo-for_psc__110156-00__asm.stp)
  Case_3 = imported_body(C:\Users\hzh66\Desktop\afrm_odo-for_psc__110156-00__asm.stp)
  Chip1 [copper] = imported_body(C:\Users\hzh66\Desktop\afrm_odo-for_psc__110156-00__asm.stp)
  Case_2 = imported_body(C:\Users\hzh66\Desktop\afrm_odo-for_psc__110156-00__asm.stp)
  Case [Al-Extruded] = imported_body(C:\Users\hzh66\Desktop\afrm_odo-for_psc__110156-00__asm.stp)
  PCB, PCB_1 [FR-4] = imported_body(C:\Users\hzh66\Desktop\afrm_odo-for_psc__110156-00__asm.stp)
  Native_Fan_1_1 = component(Native_Fan_1, Type=Fan Unit=mm ModelAs=3D Shape=Circular MovePlane=XY Radius=18.8mm HubRadius=11mm CaseSize=40mm CaseHeight=20mm CaseSide SheetID=43 BodyID=34 HubID=49 CaseID=6 FlowDirChoice=NormalNegative FlowType=Curve SwirlType=RPM SolidCaseMaterial=Al-Extruded SolidHubMaterial=Al-Extruded PassageMaterial=air DimUnits(cfm, in_water) X(0, 0.0021237635, 0.0031856452, 0.0050970324) Y(72.1636, 27.3724, 24.884, 0) Pressure_Loss_Curve{DimUnits(m_per_sec, n_per_meter_sq) X(0, 1, 2, 3) Y(1, 10, 100, 0)} IntakeTemp=AmbientTemp Swirl=8000 OperatingRPM=0 HubPower=0W Magnitude=1)
  Native_Fan_1_Case [Al-Extruded] = part_of(Native_Fan_1_1)
  Native_Fan_1_Passage [air] = part_of(Native_Fan_1_1)
  Native_Fan_1_Surface = part_of(Native_Fan_1_1)
  Native_Fan_1_Hub [Al-Extruded] = part_of(Native_Fan_1_1)
  Native_Fan_1_1.move(TranslateVectorX=31.98754mm TranslateVectorY=21.1883mm TranslateVectorZ=243.6137mm)
  Native_Fan_2_1 = component(Native_Fan_2, Type=Fan Unit=mm ModelAs=3D Shape=Circular MovePlane=XY Radius=18.8mm HubRadius=11mm CaseSize=40mm CaseHeight=20mm CaseSide SheetID=43 BodyID=34 HubID=49 CaseID=6 FlowDirChoice=NormalNegative FlowType=Curve SwirlType=RPM SolidCaseMaterial=Al-Extruded SolidHubMaterial=Al-Extruded PassageMaterial=air DimUnits(m3_per_s, n_per_meter_sq) X(0, 4.5, 6.75, 10.8) Y(0.29, 0.11, 0.1, 0) Pressure_Loss_Curve{DimUnits(m_per_sec, n_per_meter_sq) X(0, 1, 2, 3) Y(1, 10, 100, 0)} IntakeTemp=AmbientTemp Swirl=8000 OperatingRPM=0 HubPower=0W Magnitude=1)
  Native_Fan_2_Case [Al-Extruded] = part_of(Native_Fan_2_1)
  Native_Fan_2_Passage [air] = part_of(Native_Fan_2_1)
  Native_Fan_2_Surface = part_of(Native_Fan_2_1)
  Native_Fan_2_Hub [Al-Extruded] = part_of(Native_Fan_2_1)
  Native_Fan_2_1.move(TranslateVectorX=73.98754mm TranslateVectorY=21.1883mm TranslateVectorZ=219.4337mm)
  Native_Fan_3_1 = component(Native_Fan_3, Type=Fan Unit=mm ModelAs=3D Shape=Circular MovePlane=XY Radius=18.8mm HubRadius=11mm CaseSize=40mm CaseHeight=20mm CaseSide SheetID=43 BodyID=34 HubID=49 CaseID=6 FlowDirChoice=NormalNegative FlowType=Curve SwirlType=RPM SolidCaseMaterial=Al-Extruded SolidHubMaterial=Al-Extruded PassageMaterial=air DimUnits(m3_per_s, n_per_meter_sq) X(0, 4.5, 6.75, 10.8) Y(0.29, 0.11, 0.1, 0) Pressure_Loss_Curve{DimUnits(m_per_sec, n_per_meter_sq) X(0, 1, 2, 3) Y(1, 10, 100, 0)} IntakeTemp=AmbientTemp Swirl=8000 OperatingRPM=0 HubPower=0W Magnitude=1)
  Native_Fan_3_Case [Al-Extruded] = part_of(Native_Fan_3_1)
  Native_Fan_3_Passage [air] = part_of(Native_Fan_3_1)
  Native_Fan_3_Surface = part_of(Native_Fan_3_1)
  Native_Fan_3_Hub [Al-Extruded] = part_of(Native_Fan_3_1)
  Native_Fan_3_1.move(TranslateVectorX=-32.01246mm TranslateVectorY=21.1863mm TranslateVectorZ=243.6137mm)
  Native_Fan_3_1.rotate(RotateAxis=Z RotateAngle=180deg)
  Native_Fan_3_1.move(TranslateVectorX=-64.02492mm TranslateVectorY=42.3736mm TranslateVectorZ=-0.0006533817mm)
  Case_1 = imported_body(C:\Users\hzh66\Desktop\case_al-extruded.stp)
  Case.unite(Case_1)
  Case.unite(Case_2, Case_3)
  MeshRegion1_SubRegion [air, non-model] = sub_region(of=FIN, percentage_offset=0 on all sides)
  MeshRegion2_SubRegion [air, non-model] = sub_region(of=HP_2, HP_1, HP, percentage_offset=0 on all sides)
  MeshRegion3_SubRegion [air, non-model] = sub_region(of=CuBase, TIM579_1, Chip2, Chip1, TIM579, percentage_offset=0 on all sides)
  group afrm_odofor_psc__11015600__asm = FIN, CuBase, HP_2, HP, HP_1, AlBase, TIM579_1, TIM579, Chip2, PSU, Chip1, PCB, PCB_1
  group Case_4 = Case
boundaries and excitations:
  Block1: Block Objects=Chip1 Block_Type=Solid Use_Total_Power Total_Power=15W
  Block2: Block Objects=Chip2 Block_Type=Solid Use_Total_Power Total_Power=15W
  Opening1: Opening Faces=Region.face(+z) Temperature=30cel External_Rad._Temperature=AmbientRadTemp Inlet_Type=Pressure Total_Pressure=AmbientPressure
  Opening2: Opening Faces=Region.face(-z) Temperature=30cel External_Rad._Temperature=AmbientRadTemp Inlet_Type=Pressure Total_Pressure=AmbientPressure
  StationaryWall1: Stationary Wall Faces=Region.face(+x, +y, -y, -x) Thickness=0mm Solid_Material=Al-Extruded External_Condition="Heat Flux" Heat_Flux=0irrad_W_per_m2 Temperature=AmbientTemp Heat_Transfer_Coefficient=0w_per_m2kel Reference_Temperature=AmbientTemp Heat_Transfer_Data{Heat_Transfer_Convection_Type="Forced Convection"} External_Material=Steel-oxidised-surface External_Radiation_Reference_Temperature=AmbientTemp External_Radiation_View_Factor=1
mesh:
  Global:  MeshMethod=MesherHD UserSpecifiedSettings ComputeGap MaxElementSizeX=5mm MaxElementSizeY=5mm MaxElementSizeZ=5mm MinElementsInGap=2 MinElementsOnEdge=1 MaxSizeRatio=5 EnableMLM EnforeMLMType=None MaxLevels=1 BufferLayers=0 UniformMeshParametersType=Average MinGapX=1mm MinGapY=0.1mm MinGapZ=1mm Objects=Region FacetLevel=3 ProximitySizeFunction CurvatureSizeFunction OptimizePCBMesh
  MeshRegion1:  MeshMethod=MesherHD UserSpecifiedSettings MaxElementSizeX=0.5mm MaxElementSizeY=3mm MaxElementSizeZ=3mm MinElementsInGap=3 MinElementsOnEdge=2 MaxSizeRatio=2 EnableMLM EnforeMLMType=3D MaxLevels=0 BufferLayers=0 UniformMeshParametersType=Average 2DMLMType=2DMLM_None MinGapX=0.1mm MinGapY=1mm MinGapZ=1mm Objects=MeshRegion1_SubRegion ProximitySizeFunction CurvatureSizeFunction OptimizePCBMesh
  MeshRegion2:  MeshMethod=MesherHD UserSpecifiedSettings MaxElementSizeX=5mm MaxElementSizeY=0.5mm MaxElementSizeZ=5mm MinElementsInGap=3 MinElementsOnEdge=2 MaxSizeRatio=2 EnableMLM EnforeMLMType=3D MaxLevels=0 BufferLayers=0 UniformMeshParametersType=Average 2DMLMType=2DMLM_None MinGapX=1mm MinGapY=1mm MinGapZ=1mm Objects=MeshRegion2_SubRegion ProximitySizeFunction CurvatureSizeFunction OptimizePCBMesh
  MeshRegion3:  MeshMethod=MesherHD UserSpecifiedSettings MaxElementSizeX=3mm MaxElementSizeY=1mm MaxElementSizeZ=3mm MinElementsInGap=3 MinElementsOnEdge=2 MaxSizeRatio=2 EnableMLM EnforeMLMType=3D MaxLevels=0 BufferLayers=0 UniformMeshParametersType=Average 2DMLMType=2DMLM_None MinGapX=1mm MinGapY=1mm MinGapZ=1mm Objects=MeshRegion3_SubRegion ProximitySizeFunction CurvatureSizeFunction OptimizePCBMesh
monitors:
  Chip1: Quantities(19) Objects=Chip1
  Chip2: Quantities(19) Objects=Chip2
setups:
  Setup1: IcepakSteadyState Flow_Regime=Turbulent Turbulent_Model_Eqn=ZeroEquation Include_Temperature=true Include_Flow=true Solution_Initialization_-_Temperature=30cel Solution_Initialization_-_Turbulent_Kinetic_Energy=1m2_per_s2 Solution_Initialization_-_Turbulent_Dissipation_Rate=1m2_per_s3 Solution_Initialization_-_Specific_Dissipation_Rate=1diss_per_s Convergence_Criteria_-_Flow=1e-07 Convergence_Criteria_-_Energy=1e-07 Convergence_Criteria_-_Turbulent_Kinetic_Energy=0.001 Convergence_Criteria_-_Turbulent_Dissipation_Rate=0.001 Convergence_Criteria_-_Specific_Dissipation_Rate=0.001 GPU_Convergence_Criteria_-_Flow=0.001 GPU_Convergence_Criteria_-_Energy=1e-05 GPU_Convergence_Criteria_-_Turbulent_Kinetic_Energy=0.001 GPU_Convergence_Criteria_-_Turbulent_Dissipation_Rate=0.001 GPU_Convergence_Criteria_-_Specific_Dissipation_Rate=0.001 disabled Radiation_Model=Off Under-relaxation_-_Pressure=0.3 Under-relaxation_-_Momentum=0.7 Under-relaxation_-_Temperature=1 Under-relaxation_-_Turbulent_Kinetic_Energy=0.8 Under-relaxation_-_Turbulent_Dissipation_Rate=0.8 Under-relaxation_-_Specific_Dissipation_Rate=0.8 Discretization_Scheme_-_Pressure=Standard Discretization_Scheme_-_Momentum=First Discretization_Scheme_-_Temperature=First Discretization_Scheme_-_Turbulent_Kinetic_Energy=First Discretization_Scheme_-_Turbulent_Dissipation_Rate=First Discretization_Scheme_-_Specific_Dissipation_Rate=First Convergence_Criteria_-_Max_Iterations=500
